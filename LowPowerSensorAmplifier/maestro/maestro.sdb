ADE simulation setup
Run mode: Single Run, Sweeps and Corners
Tests:
  Analog_projects_LowPowerSensorAmplifier_1: Analog_projects/LowPowerSensorAmplifier/schematic, simulator spectre
    Variables: wireopt = 211; L = 241n; W13 = 160n; W24 = 940n; W1 = W13; W2 = W24; W3 = W13; W4 = W24; W5 = 1.65u; W6 = 530n; L1 = L; L2 = L; L3 = L; L4 = L; L5 = 436n; L6 = 320n; R1 = 18k; R2 = 398k; VinDC = 0.395; Rs = 100k
    Outputs: M5-Sat; In current
  Analog_projects_LowPowerSensorAmplifier_1_1: Analog_projects/LowPowerSensorAmplifier/schematic, simulator spectre
    Variables: wireopt = 211; L = 120n; W13 = 800n; W24 = W13; W1 = W13; W2 = W24; W3 = W13; W4 = W24; W5 = 1.2u; W6 = 160n; L1 = L; L2 = L; L3 = L; L4 = L; L5 = 120n; L6 = 40u; R1 = 123k; R2 = 40k; VinDC = 395m; Rs = 100k
