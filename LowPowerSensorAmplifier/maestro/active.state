ADE simulation setup
Test Analog_projects_LowPowerSensorAmplifier_1_1: Analog_projects/LowPowerSensorAmplifier/schematic, simulator spectre
  Models: /data/ibm/bicmos8hp/V1.6.0.0HP/Spectre/models/wafer.scs, /data/ibm/bicmos8hp/V1.6.0.0HP/Spectre/models/design.scs, /data/ibm/bicmos8hp/V1.6.0.0HP/Spectre/models/allModels.scs[tt]
  Variables: wireopt = 211; L = 120n; W6 = 160n; L6 = 40u; R1 = 123k; R2 = 40k; VinDC = 395m; Rs = 100k; W13 = 800n; L5 = 120n; W5 = 1.2u; W24 = W13; L1 = L; L2 = L; L3 = L; L4 = L; W1 = W13; W3 = W13; W2 = W24; W4 = W24
  Temperature: 27
  Operating points saved: /M1 (vds vgs vth); /M3 (vds vgs vth)
  Analysis dc: sweep R1 start=1 stop=100M (saves the operating point)
  Output VS("/Vb")
  Output M1-Sat = ((OS("/M1" "vds") - OS("/M1" "vgs")) + OS("/M1" "vth"))
  Output M3-Sat = ((OS("/M3" "vds") - OS("/M3" "vgs")) + OS("/M3" "vth"))
  Output Cutoff1 = (OS("/M1" "vgs") - OS("/M1" "vth"))
  Output Cutoff3 = (OS("/M3" "vgs") - OS("/M3" "vth"))
  Output Vds1 = OS("/M1" "vds")
  Output Vds3 = OS("/M3" "vds")
  Output IS("/M3/D")
  Signals: /M5/G (terminal), /M5/S (terminal), /M5/D (terminal), /M5/B (terminal), /M4/G (terminal), /M4/D (terminal), /M4/S (terminal), /M4/B (terminal), /M2/G (terminal), /M2/D (terminal), /M2/S (terminal), /M2/B (terminal), /M1/G (terminal), /M1/D (terminal), /M1/S (terminal), /M1/B (terminal), /M3/G (terminal), /M3/D (terminal), /M3/S (terminal), /M3/B (terminal), /M6/G (terminal), /M6/D (terminal), /M6/S (terminal), /M6/B (terminal), /Vb
Test Analog_projects_LowPowerSensorAmplifier_1: Analog_projects/LowPowerSensorAmplifier/schematic, simulator spectre
  Models: /data/ibm/bicmos8hp/V1.6.0.0HP/Spectre/models/wafer.scs, /data/ibm/bicmos8hp/V1.6.0.0HP/Spectre/models/design.scs, /data/ibm/bicmos8hp/V1.6.0.0HP/Spectre/models/allModels.scs[tt]
  Variables: wireopt = 211; L = 241n; W24 = 940n; W5 = 1.65u; W6 = 530n; L5 = 436n; L6 = 320n; R1 = 18k; R2 = 398k; VinDC = 0.395; Rs = 100k; W13 = 160n; W2 = W24; W4 = W24; L1 = L; L2 = L; L3 = L; L4 = L; W1 = W13; W3 = W13
  Temperature: 27
  Operating points saved: /M2 (rout vth vgs vds); /M4 (rout gm vth vgs vds); /M5 (gm vth vgs vds rout); /M1 (vth vgs vds); /M3 (vth vgs vds)
  Analysis dc: sweep VinDC start=0 stop=0.8 (saves the operating point)
  Output VS("/Vb") (unticked)
  Output Current Ratio = (IS("/M4/D") / IS("/M3/D"))
  Output Out Current = IS("/M4/D")
  Output (dB20(VF("/Vout")) - dB20(VF("/Vin")))
  Output M2-Sat = ((OS("/M2" "vds") - OS("/M2" "vgs")) + OS("/M2" "vth"))
  Output M4-Sat = ((OS("/M4" "vds") - OS("/M4" "vgs")) + OS("/M4" "vth"))
  Output M5-Sat = (OS("/M5" "vgs") - OS("/M5" "vds") - OS("/M5" "vth"))
  Output Cutoff2 = (OS("/M2" "vgs") - OS("/M2" "vth"))
  Output Cutoff4 = (OS("/M4" "vgs") - OS("/M4" "vth"))
  Output Cutoff5 = (OS("/M5" "vth") - OS("/M5" "vgs"))
  Output Rout5 = OS("/M5" "rout")
  Output Rout4 = (OS("/M4" "gm") * OS("/M4" "rout") * OS("/M2" "rout"))
  Output Vds2 = OS("/M2" "vds")
  Output Vds5 = OS("/M5" "vds")
  Output gm5=40u = OS("/M5" "gm")
  Output Rout = ((OS("/M4" "gm") * OS("/M4" "rout") * OS("/M2" "rout") * OS("/M5" "rout")) / ((OS("/M4" "gm") * OS("/M4" "rout") * OS("/M2" "rout")) + OS("/M5" "rout")))
  Output Vds1 = OS("/M1" "vds")
  Output Vds3 = OS("/M3" "vds")
  Output M1-Sat = ((OS("/M1" "vds") - OS("/M1" "vgs")) + OS("/M1" "vth"))
  Output M3-Sat = ((OS("/M3" "vds") - OS("/M3" "vgs")) + OS("/M3" "vth"))
  Output In current = IS("/M3/D")
  Output Cutoff1 = (OS("/M1" "vgs") - OS("/M1" "vth"))
  Output Cutoff3 = (OS("/M3" "vgs") - OS("/M3" "vth"))
  Signals: /M5/G (terminal), /M5/S (terminal), /M5/D (terminal), /M5/B (terminal), /M4/G (terminal), /M4/D (terminal), /M4/S (terminal), /M4/B (terminal), /M2/G (terminal), /M2/D (terminal), /M2/S (terminal), /M2/B (terminal), /M1/G (terminal), /M1/D (terminal), /M1/S (terminal), /M1/B (terminal), /M3/G (terminal), /M3/D (terminal), /M3/S (terminal), /M3/B (terminal), /M6/G (terminal), /M6/D (terminal), /M6/S (terminal), /M6/B (terminal), /Vb, /Vout, /Vin
Run mode: Single Run, Sweeps and Corners
