ADE simulation setup
Test Analog_projects_Test1_1: Analog_projects/Test1/schematic, simulator spectre
  Models: /data/ibm/bicmos8hp/V1.6.0.0HP/Spectre/models/wafer.scs, /data/ibm/bicmos8hp/V1.6.0.0HP/Spectre/models/design.scs, /data/ibm/bicmos8hp/V1.6.0.0HP/Spectre/models/allModels.scs[tt]
  Variables: Vsin = 0.2m; Lcm = 120n; Lncm2 = 120n; Lpcm = 120n; Wcm = 160n; Wncm2 = 160n; Wpcm = 160n; W2 = 160n; L2 = 160n; Vg2 = 0.5; Wn2 = 412n; Ln2 = 14.3u; Vgn2 = 0.7; Wp = 160n; Lp = 2.5u; Vb1 = 1.4; Wn = 432n; Ln = 100u; Vb2 = 0.6; W = 160n; L = 1u; Vg = 0; R = 1k; wireopt = 211; Cf = 5p; Ct = 10p; Cf12 = 5p; CL = 10p; f = 20; VsinPhase = 0; Vcmbn = 1.6; T = 1/f
  Temperature: 27
  Operating points saved: /T10 (gds gm vds ids vth vgs); /T11 (vgs vth vds ids); /T8 (vds vth vgs ids gds); /T14 (gds gm vds ids vth vgs); /T12 (vds vth vgs ids gds)
  Analysis dc: sweep Vcmbn start=1 stop=2 (saves the operating point)
  Output On state = (OS("/T10" "vgs") - OS("/T10" "vth")) (unticked)
  Output Current = OS("/T10" "ids") (unticked)
  Output Sat state = ((OS("/T10" "vds") - OS("/T10" "vgs")) + OS("/T10" "vth")) (unticked)
  Output Gain = (OS("/T10" "gm") / OS("/T10" "gds")) (unticked)
  Output gds = OS("/T10" "gds") (unticked)
  Output Ratio ids/gds = (OS("/T10" "ids") / OS("/T10" "gds")) (unticked)
  Output Mirror on = (OS("/T11" "vgs") - OS("/T11" "vth")) (unticked)
  Output Mirror sat = ((OS("/T11" "vds") - OS("/T11" "vgs")) + OS("/T11" "vth")) (unticked)
  Output Mirror current = OS("/T11" "ids") (unticked)
  Output MirrorN gds = OS("/T8" "gds") (unticked)
  Output MirrorN current = OS("/T8" "ids") (unticked)
  Output MirrorN on = (OS("/T8" "vgs") - OS("/T8" "vth")) (unticked)
  Output MirrorN sat = ((OS("/T8" "vds") - OS("/T8" "vgs")) + OS("/T8" "vth")) (unticked)
  Output MirrorN ratio = (OS("/T8" "ids") / OS("/T8" "gds")) (unticked)
  Output Gain Bode = (dB20((VF("/Vo2") - VF("/Vo1"))) - dB20((VF("/Vin1") - VF("/Vin2")))) (unticked)
  Output Gain Bode V = (VF("/Vo2") - VF("/Vo1") - (VF("/Vin1") - VF("/Vin2"))) (unticked)
  Output On state2 = (OS("/T14" "vgs") - OS("/T14" "vth")) (unticked)
  Output Current2 = OS("/T14" "ids") (unticked)
  Output Sat state2 = ((OS("/T14" "vds") - OS("/T14" "vgs")) + OS("/T14" "vth")) (unticked)
  Output Gain2 = (OS("/T14" "gm") / OS("/T14" "gds")) (unticked)
  Output gds2 = OS("/T14" "gds") (unticked)
  Output gm2 = OS("/T14" "gm") (unticked)
  Output Ratio ids/gds2 = (OS("/T14" "ids") / OS("/T14" "gds")) (unticked)
  Output MirrorN2 gds = OS("/T12" "gds") (unticked)
  Output MirrorN2 current = OS("/T12" "ids") (unticked)
  Output MirrorN2 on = (OS("/T12" "vgs") - OS("/T12" "vth")) (unticked)
  Output MirrorN2 sat = ((OS("/T12" "vds") - OS("/T12" "vgs")) + OS("/T12" "vth")) (unticked)
  Output MirrorN2 ratio = (OS("/T12" "ids") / OS("/T12" "gds")) (unticked)
  Output Vout AC = VF("/Vof1")
  Output Vout1 AC = VF("/Vo1") (unticked)
  Output Vfeedback1 = VF("/Vf1") (unticked)
  Output Vout phase = phaseDegUnwrapped(VF("/Vof1")) (unticked)
  Output Gain transient = ((VT("/Vo2") - VT("/Vo1")) / (VT("/Vin1") - VT("/Vin2"))) (unticked)
  Output Input transient = (VT("/Vin1") - VT("/Vin2")) (unticked)
  Output output transient = (VT("/Vo2") - VT("/Vo1")) (unticked)
  Output v /Vof1; tran (V) = vtime('tran "/Vof1") (unticked)
  Output VS("/T22/D")
  Output VS("/net23")
  Output E4 = (OS("/T10" "vgs") - OS("/T10" "vth"))
  Output E5 = OS("/T10" "ids")
  Output (OS("/T10" "vgs") - OS("/T10" "vth"))
  Signals: /T11/G (terminal), /T11/S (terminal), /T11/D (terminal), /T11/B (terminal), /T10/G (terminal), /T10/S (terminal), /T10/D (terminal), /T10/B (terminal), /Vo2, /Vo1, /Vin1, /Vin2, /Vf1, /T22/D (terminal) as /T22/D_V
Test Analog_projects_Test_CMFBtst: Analog_projects/Test1/schematic, simulator spectre
  Models: /data/ibm/bicmos8hp/V1.6.0.0HP/Spectre/models/wafer.scs, /data/ibm/bicmos8hp/V1.6.0.0HP/Spectre/models/design.scs, /data/ibm/bicmos8hp/V1.6.0.0HP/Spectre/models/allModels.scs[tt]
  Variables: Wn2 = 558n; Wp = 160n; Lp = 495n; Ln = 15.6u; Wn = 160n; W2 = 3.1u; L2 = 120n; W = 674n; L = 200n; Ln2 = 120n; Vb1 = 1.4; Vgn2 = 0.6; Vgt2 = 0.7; Vgp2 = 0.6; Vbncm2 = 0.6; Lncm2 = 313n; Lpcm2 = 210n; Lpcm = 190n; Lcm = 120n; Wcm = 160n; Wncm2 = 160n; Wpcm = 160n; Vg2 = 0.5; Vb2 = 0.6; Vg = 0; wireopt = 211; Ct = 100p; CL = 10p; Vsin = 275m; f = 1k; VsinPhase = 180; Ccmfb = 100p; Rc = 90k; Cf12 = 0.1p; Cf = 1p; T = 1/f
  Temperature: 27
  Operating points saved: /T23 (vth vgs vds); /T24 (vth vgs vds); /T25 (vth vgs vds); /T10 (vgs vth ids vds gm); /T8 (gds vds vth vgs ids); /T11 (ids vds vth vgs); /T14 (vds vth vgs ids gds gm); /T12 (vds vth vgs ids gm gds)
  Analysis dc: (saves the operating point)
  Output sat n = ((OS("/T23" "vds") - OS("/T23" "vgs")) + OS("/T23" "vth")) (unticked)
  Output on n = (OS("/T23" "vgs") - OS("/T23" "vth")) (unticked)
  Output current n = IS("/T23/D") (unticked)
  Output current p = IS("/T24/D") (unticked)
  Output sat p = ((OS("/T24" "vds") - OS("/T24" "vgs")) + OS("/T24" "vth")) (unticked)
  Output on p = (OS("/T24" "vgs") - OS("/T24" "vth")) (unticked)
  Output sat25 = ((OS("/T25" "vds") - OS("/T25" "vgs")) + OS("/T25" "vth")) (unticked)
  Output on25 = (OS("/T25" "vgs") - OS("/T25" "vth")) (unticked)
  Output current25 = IS("/T25/D") (unticked)
  Output gain = (OS("/T10" "gm") / OS("/T10" "gds")) (unticked)
  Output gds = OS("/T10" "gds") (unticked)
  Output ratio = (OS("/T10" "ids") / OS("/T10" "gds")) (unticked)
  Output on = (OS("/T10" "vgs") - OS("/T10" "vth")) (unticked)
  Output current = OS("/T10" "ids") (unticked)
  Output sat = ((OS("/T10" "vds") - OS("/T10" "vgs")) + OS("/T10" "vth")) (unticked)
  Output gm = OS("/T10" "gm") (unticked)
  Output MirrorNcurrent = OS("/T8" "ids") (unticked)
  Output MirrorNon = (OS("/T8" "vgs") - OS("/T8" "vth")) (unticked)
  Output MirrorNsat = ((OS("/T8" "vds") - OS("/T8" "vgs")) + OS("/T8" "vth")) (unticked)
  Output MirrorNratio = (OS("/T8" "ids") / OS("/T8" "gds")) (unticked)
  Output MirrorNgds = OS("/T8" "gds") (unticked)
  Output MirrorOn = (OS("/T11" "vgs") - OS("/T11" "vth")) (unticked)
  Output MirrorSat = ((OS("/T11" "vds") - OS("/T11" "vgs")) + OS("/T11" "vth")) (unticked)
  Output MirrorCurrent = OS("/T11" "ids") (unticked)
  Output gain2P = (OS("/T14" "gm") / OS("/T14" "gds")) (unticked)
  Output gds2P = OS("/T14" "gds") (unticked)
  Output ratio2P = (OS("/T14" "ids") / OS("/T14" "gds")) (unticked)
  Output on2P = (OS("/T14" "vgs") - OS("/T14" "vth")) (unticked)
  Output current2P = OS("/T14" "ids") (unticked)
  Output sat2P = ((OS("/T14" "vds") - OS("/T14" "vgs")) + OS("/T14" "vth")) (unticked)
  Output gm2P = OS("/T14" "gm") (unticked)
  Output gds2 = OS("/T12" "gds") (unticked)
  Output gain2 = (OS("/T12" "gm") / OS("/T12" "gds")) (unticked)
  Output ratio2 = (OS("/T12" "ids") / OS("/T12" "gds")) (unticked)
  Output on2 = (OS("/T12" "vgs") - OS("/T12" "vth")) (unticked)
  Output current2 = OS("/T12" "ids") (unticked)
  Output sat2 = ((OS("/T12" "vds") - OS("/T12" "vgs")) + OS("/T12" "vth")) (unticked)
  Output gm2 = OS("/T12" "gm") (unticked)
  Output gmRatio2P = (OS("/T14" "ids") / OS("/T14" "gm")) (unticked)
  Output gmRatio2 = (OS("/T12" "ids") / OS("/T12" "gm")) (unticked)
  Output mag = vfreq('ac "/Vof1") (unticked)
  Output phase = phaseDegUnwrapped(vfreq('ac "/Vof1")) (unticked)
  Signals: /T23/G (terminal), /T23/D (terminal), /T23/S (terminal), /T23/B (terminal), /T24/G (terminal), /T24/S (terminal), /T24/D (terminal), /T24/B (terminal), /T25/G (terminal), /T25/D (terminal), /T25/S (terminal), /T25/B (terminal), /T26/G (terminal), /T26/S (terminal), /T26/B (terminal), /T2/G (terminal), /T2/S (terminal), /T2/D (terminal), /T2/B (terminal), /T1/G (terminal), /T1/D (terminal), /T1/S (terminal), /T1/B (terminal), /T3/G (terminal), /T3/D (terminal), /T3/S (terminal), /T3/B (terminal), /T5/G (terminal), /T5/S (terminal), /T5/D (terminal), /T5/B (terminal), /T4/G (terminal), /T4/S (terminal), /T4/D (terminal), /T4/B (terminal), /T14/G (terminal), /T14/S (terminal), /T14/D (terminal), /T14/B (terminal), /Vin1, /Vf1, /net17, /gnd!, /vdd!, /net16, /net4, /net9, /net6, /net5, /net1, /net8, /net18, /V14/MINUS (terminal), /V14/PLUS (terminal), /V11/MINUS (terminal), /V11/PLUS (terminal), /V9/MINUS (terminal), /V9/PLUS (terminal), /V6/MINUS (terminal), /V6/PLUS (terminal), /V7/MINUS (terminal), /V7/PLUS (terminal), /V17/MINUS (terminal), /V17/PLUS (terminal), /T8/G (terminal), /T8/D (terminal), /T8/S (terminal), /T8/B (terminal), /T11/G (terminal), /T11/S (terminal), /T11/D (terminal), /T11/B (terminal), /V12/MINUS (terminal), /V12/PLUS (terminal), /V15/MINUS (terminal), /V15/PLUS (terminal), /C4/PLUS (terminal), /C4/MINUS (terminal)
Test Analog_projects_Test_CMFBtst_1: Analog_projects/Test1/schematic, simulator spectre
  Models: /data/ibm/bicmos8hp/V1.6.0.0HP/Spectre/models/wafer.scs, /data/ibm/bicmos8hp/V1.6.0.0HP/Spectre/models/design.scs, /data/ibm/bicmos8hp/V1.6.0.0HP/Spectre/models/allModels.scs[tt]
  Variables: Lb2 = 10u; R = 1.4M; Wb2 = 160n; Lb = 50.42u; Lbp = 60u; Wb = 160n; Wbp = 160n; Wn2 = 33u; Ln2 = 120n; W2 = 162u; L2 = 120n; Wp = 10.6u; Lp = 120n; Ln = 200n; Wn = 1.4u; W = 90u; L = 200n; Vb1 = 1.4; Vgn2 = 0.6; Vgt2 = 0.7; Vgp2 = 0.6; Vbncm2 = 0.6; Lncm2 = 313n; Lpcm2 = 210n; Lpcm = 190n; Lcm = 120n; Wcm = 160n; Wncm2 = 160n; Wpcm = 160n; Vg2 = 0.5; Vb2 = 0.6; Vg = 0; wireopt = 211; Ct = 100p; CL = 10p; Vsin = 275m; f = 1k; VsinPhase = 0; Ccmfb = 100p; Rc = 0; Cf12 = 4.5p; Cf = 1.8p; n1 = 4.5; n2 = 1; T = 1/f
  Temperature: 27
  Operating points saved: /T14 (gm); /T12 (ids); /T10 (gm); /T8 (ids); /T11 (ids)
  Analysis noise: start=1m stop=100G p=/Vof1 n=/Vof2 iprobe=/V5
  Analysis dc: sweep R start=1 stop=2M (saves the operating point)
  Output OS("/T14" "gm") (unticked)
  Output OS("/T12" "ids") (unticked)
  Output v /Vof1; ac mag(V) = vfreq('ac "/Vof1") (unticked)
  Output v /Vof1; ac deg(V) = phaseDegUnwrapped(vfreq('ac "/Vof1")) (unticked)
  Output OS("/T10" "gm") (unticked)
  Output OS("/T8" "ids") (unticked)
  Output OS("/T11" "ids") (unticked)
  Output VT("/Vof1") (unticked)
  Output diff sig = (VT("/Vof1") - VT("/Vof2")) (unticked)
  Output VS("/Vb_Sink") (unticked)
  Output IS("/T31/D") (unticked)
  Output Loop Gain Phase = phaseDegUnwrapped(getData("loopGain" ?result "stb"))
  Output Loop Gain dB20 = db(mag(getData("loopGain" ?result "stb")))
  Signals: /T24/D (terminal), /T25/D (terminal), /T29/G (terminal), /T29/D (terminal), /T29/S (terminal), /T29/B (terminal), /T14/G (terminal), /T14/S (terminal), /T14/D (terminal), /T14/B (terminal), /T12/G (terminal), /T12/D (terminal), /T12/S (terminal), /T12/B (terminal), /Vof1, /Vof2, /T32/G (terminal), /T32/S (terminal), /T32/D (terminal), /T32/B (terminal), /T31/G (terminal), /T31/D (terminal), /T31/S (terminal), /T31/B (terminal), /Vb_Sink
Run mode: Single Run, Sweeps and Corners
