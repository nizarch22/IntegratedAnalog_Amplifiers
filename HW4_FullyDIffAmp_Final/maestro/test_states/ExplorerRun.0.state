ADE simulation setup
Test Analog_projects_Test_CMFBtst_1: Analog_projects/Test1/schematic, simulator spectre
  Models: /data/ibm/bicmos8hp/V1.6.0.0HP/Spectre/models/wafer.scs, /data/ibm/bicmos8hp/V1.6.0.0HP/Spectre/models/design.scs, /data/ibm/bicmos8hp/V1.6.0.0HP/Spectre/models/allModels.scs[tt]
  Variables: Lb2 = 10u; R = 1.4M; Wb2 = 160n; Lb = 50.42u; Lbp = 60u; Wb = 160n; Wbp = 160n; Wn2 = 33u; Ln2 = 120n; W2 = 162u; L2 = 120n; Wp = 10.6u; Lp = 120n; Ln = 200n; Wn = 1.4u; W = 90u; L = 200n; Vb1 = 1.4; Vgn2 = 0.6; Vgt2 = 0.7; Vgp2 = 0.6; Vbncm2 = 0.6; Lncm2 = 313n; Lpcm2 = 210n; Lpcm = 190n; Lcm = 120n; Wcm = 160n; Wncm2 = 160n; Wpcm = 160n; Vg2 = 0.5; Vb2 = 0.6; Vg = 0; wireopt = 211; Ct = 100p; CL = 10p; Vsin = 275m; f = 1k; VsinPhase = 0; Ccmfb = 100p; Rc = 0; Cf12 = 4.5p; Cf = 1.8p; n1 = 4.5; n2 = 1; T = 1/f
  Temperature: 27
  Operating points saved: /T14 (gm); /T12 (ids); /T10 (gm); /T8 (ids); /T11 (ids)
  Analysis noise: start=1m stop=100G p=/Vof1 n=/Vof2 iprobe=/V5
  Analysis dc: sweep R start=1 stop=2M (saves the operating point)
  Output OS("/T14" "gm") (unticked)
  Output OS("/T12" "ids") (unticked)
  Output v /Vof1; ac mag(V) = vfreq('ac "/Vof1") (unticked)
  Output v /Vof1; ac deg(V) = phaseDegUnwrapped(vfreq('ac "/Vof1")) (unticked)
  Output OS("/T10" "gm") (unticked)
  Output OS("/T8" "ids") (unticked)
  Output OS("/T11" "ids") (unticked)
  Output VT("/Vof1") (unticked)
  Output diff sig = (VT("/Vof1") - VT("/Vof2")) (unticked)
  Output VS("/Vb_Sink") (unticked)
  Output IS("/T31/D") (unticked)
  Output Loop Gain Phase = phaseDegUnwrapped(getData("loopGain" ?result "stb"))
  Output Loop Gain dB20 = db(mag(getData("loopGain" ?result "stb")))
  Signals: /T24/D (terminal), /T25/D (terminal), /T29/G (terminal), /T29/D (terminal), /T29/S (terminal), /T29/B (terminal), /T14/G (terminal), /T14/S (terminal), /T14/D (terminal), /T14/B (terminal), /T12/G (terminal), /T12/D (terminal), /T12/S (terminal), /T12/B (terminal), /Vof1, /Vof2, /T32/G (terminal), /T32/S (terminal), /T32/D (terminal), /T32/B (terminal), /T31/G (terminal), /T31/D (terminal), /T31/S (terminal), /T31/B (terminal), /Vb_Sink
