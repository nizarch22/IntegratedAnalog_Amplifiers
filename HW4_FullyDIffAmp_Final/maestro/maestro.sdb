ADE simulation setup
Run mode: Single Run, Sweeps and Corners
Tests:
  Analog_projects_Test1_1: Analog_projects/Test1/schematic, simulator spectre
    Variables: W2 = 160n; L2 = 160n; Vg2 = 0.5; Wn2 = 412n; Ln2 = 14.3u; Vgn2 = 0.7; Wp = 160n; Lp = 2.5u; Vb1 = 1.4; Wn = 432n; Ln = 100u; Vb2 = 0.6; W = 160n; L = 1u; Vg = 0; R = 1k; wireopt = 211; Cf = 5p; Ct = 10p; Cf12 = 5p; CL = 10p; Lcm = 120n; Lncm2 = 120n; Lpcm = 120n; Wcm = 160n; Wncm2 = 160n; Wpcm = 160n; Vsin = 0.2m; T = 1/f; f = 20; VsinPhase = 0; Vcmbn = 1.6
    Outputs: Vout AC
  Analog_projects_Test_CMFBtst: Analog_projects/Test1/schematic, simulator spectre
    Variables: Wn2 = 558n; Wp = 160n; Lp = 495n; Ln = 15.6u; Wn = 160n; W2 = 3.1u; L2 = 120n; W = 674n; L = 200n; Ln2 = 120n; Vb1 = 1.4; Vgn2 = 0.6; Vgt2 = 0.7; Vgp2 = 0.6; Vbncm2 = 0.6; Lncm2 = 313n; Lpcm2 = 210n; Lpcm = 190n; Lcm = 120n; Wcm = 160n; Wncm2 = 160n; Wpcm = 160n; Vg2 = 0.5; Vb2 = 0.6; Vg = 0; wireopt = 211; Ct = 100p; CL = 10p; Vsin = 275m; T = 1/f; f = 1k; VsinPhase = 180; Ccmfb = 100p; Rc = 90k; Cf12 = 0.1p; Cf = 1p
    Outputs: gm2P
  Analog_projects_Test_CMFBtst_1: Analog_projects/HW4_FullyDIffAmp_Final/schematic, simulator spectre
    Variables: Wn2 = 33u; Ln2 = 120n; W2 = 162u; L2 = 120n; Wp = 10.6u; Lp = 120n; Ln = 200n; Wn = 1.4u; W = 90u; L = 200n; Vb1 = 1.4; Vgn2 = 0.6; Vgt2 = 0.7; Vgp2 = 0.6; Vbncm2 = 0.6; Lncm2 = 313n; Lpcm2 = 210n; Lpcm = 190n; Lcm = 120n; Wcm = 160n; Wncm2 = 160n; Wpcm = 160n; Vg2 = 0.5; Vb2 = 0.6; Vg = 0; wireopt = 211; Ct = 100p; CL = 10p; Vsin = 275m; T = 1/f; f = 1k; VsinPhase = 0; Ccmfb = 100p; Rc = 0; Cf12 = 4.5p; Cf = 1.8p; Lb = 50.42u; Lbp = 60u; Wb = 160n; Wbp = 160n; n1 = 4.5; n2 = 1; Lb2 = 10u; R = 1.4M; Wb2 = 160n
