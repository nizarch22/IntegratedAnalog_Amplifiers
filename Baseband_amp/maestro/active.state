ADE simulation setup
Test Analog_projects_Baseband_amp_1: Analog_projects/Baseband_amp/schematic, simulator spectre
  Models: /data/ibm/bicmos8hp/V1.6.0.0HP/Spectre/models/wafer.scs, /data/ibm/bicmos8hp/V1.6.0.0HP/Spectre/models/design.scs, /data/ibm/bicmos8hp/V1.6.0.0HP/Spectre/models/allModels.scs[tt]
  Variables: W = 635n; L = 120n; W2 = 620n; R = 30k; Vsin = 1m; Wn = 4.13u; Ln = 120n; wireopt = 211; W1 = 160n; Wp = 2.4u; L1 = L; L2 = L; Lp = L
  Temperature: 27
  Analysis dc: (saves the operating point)
  Signals: /vdd!, /net2, /vout, /vin
Run mode: Single Run, Sweeps and Corners
