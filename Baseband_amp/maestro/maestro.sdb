ADE simulation setup
Run mode: Single Run, Sweeps and Corners
Tests:
  Analog_projects_Baseband_amp_1: Analog_projects/Baseband_amp/schematic, simulator spectre
    Variables: W = 635n; L = 120n; W2 = 620n; W1 = 160n; L1 = L; L2 = L; R = 30k; Vsin = 1m; Wn = 4.13u; Ln = 120n; Wp = 2.4u; Lp = L; wireopt = 211
    Outputs: (dB20(VF("/vout")) - dB20(VF("/vnet3"))); "/ו"; (dB20(VF("/vout")) - dB20(VF("/net2"))); OS("/T9" "vearly"); OS("/T2" "vds"); "/IS(\"/T0/S\")"; VS("/T0/S")
